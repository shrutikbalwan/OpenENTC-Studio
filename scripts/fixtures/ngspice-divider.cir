* deterministic resistor divider
V1 in 0 9
R1 in out 1k
R2 out 0 1k
.op
.control
run
print v(out)
quit
.endc
.end
